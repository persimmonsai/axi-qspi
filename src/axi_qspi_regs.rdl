addrmap axi_qspi_regs {
    name = "AXI SPI Controller Registers";
    desc = "Register map for the AXI SPI Controller";

    default regwidth = 32;
    default sw = rw;
    default hw = r;

    signal {
        cpuif_reset;
        field_reset;
        async;
        activelow;
    } rst_n;

    reg {
        name = "Status and Control Register";
        field {
            name = "Software Reset";
            desc = "Write 1 to trigger software reset";
            sw = w;
            hw = r;
            singlepulse; 
            reset = 0;
        } sw_rst[4:4];

        field {
            name = "Trigger RX";
            desc = "Write 1 to trigger RX operation";
            sw = w;
            hw = r;
            singlepulse;
            reset = 0;
        } trig_rx[8:8];

        field {
            name = "Trigger TX";
            desc = "Write 1 to trigger TX operation";
            sw = w;
            hw = r;
            singlepulse;
            reset = 0;
        } trig_tx[9:9];

        field {
            name = "RX FIFO Elements";
            desc = "Number of elements in RX FIFO";
            sw = r;
            hw = w;
        } rx_cnt[19:16];

        field {
            name = "TX FIFO Elements";
            desc = "Number of elements in TX FIFO";
            sw = r;
            hw = w;
        } tx_cnt[27:24];
    } STATUS @0x00;

    reg {
        name = "Clock Divider";
        field {
            name = "Divisor";
            desc = "Clock Divider Value. F_spi = F_clk / (2 * (div + 1))";
            sw = rw;
            hw = r;
            reset = 2;
        } div[7:0];
        field {
            name = "Bypass Divider";
            desc = "If 1, bypass divider (F_spi = F_clk)";
            sw = rw;
            hw = r;
            reset = 0;
        } bypass[8:8];
        field {
            name = "Clock Polarity";
            desc = "0: Idle Low (Mode 0), 1: Idle High (Mode 3)";
            sw = rw;
            hw = r;
            reset = 0;
        } cpol[31:31];
    } CLKDIV @0x04;

    reg {
        name = "SPI Command";
        field {
            name = "Command";
            sw = rw;
            hw = r;
            reset = 0;
        } cmd[31:0];
    } SPICMD @0x08;

    reg {
        name = "SPI Address";
        field {
            name = "Address";
            sw = rw;
            hw = r;
            reset = 0;
        } addr[31:0];
    } SPIADR @0x0C;

    reg {
        name = "SPI Lengths";
        field {
            name = "Lengths";
            desc = "[7:0] Cmd Len, [15:8] Addr Len, [31:16] Data Len";
            sw = rw;
            hw = r;
            reset = 0;
        } len[31:0];
    } SPILEN @0x10;

    reg {
        name = "SPI Dummy Cycles";
        field {
            name = "Dummy";
            sw = rw;
            hw = r;
            reset = 0;
        } dum[31:0];
    } SPIDUM @0x14;

    reg {
        name = "SPI Mode Byte";
        desc = "Optional mode-byte (M7-M0) phase for manual commands, sent
                after the ADDR phase and before DUMMY -- required by real
                Quad/Dual I/O opcodes (e.g. 0xEB, 0xBB) that interleave a
                mode byte between address and dummy cycles at the same I/O
                width as the address phase (SPICMD's own [29:28] addr_mode
                field). Reset value len=0 disables this phase entirely,
                preserving prior behavior for every opcode that doesn't
                need it (0x03/0x0B/0x3B/0x6B/etc).";
        field {
            name = "Mode Value";
            desc = "Mode byte value to shift out, e.g. 0xFF to explicitly
                    disengage a flash's continuous-read mode.";
            sw = rw;
            hw = r;
            reset = 0;
        } val[7:0];
        field {
            name = "Mode Length";
            desc = "Mode-byte phase length in bits. 0 disables the phase;
                    8 is the typical value for real Quad/Dual I/O opcodes.";
            sw = rw;
            hw = r;
            reset = 0;
        } len[15:8];
    } SPIMODE @0x54;

    reg {
        name = "TX FIFO Data";
        field {
            name = "Data";
            sw = w;
            hw = r;
            swacc; // Software access signal generation
        } data[31:0];
    } TXFIFO @0x18;

    // RXFIFO @ 0x20
    // Skip 0x1C

    reg {
        name = "RX FIFO Data";
        field {
            name = "Data";
            sw = r;
            hw = w;
            swacc; // Signal read access
        } data[31:0];
    } RXFIFO @0x20;

    reg {
        name = "CS Default";
        field {
            name = "Default SC";
            sw = rw;
            hw = r;
            reset = 0; // Initialize to 0 (CS0 selected)
        } cs[31:0];
    } CS_DEF @0x24;

    reg {
        name = "CS 0 Base Address";
        field {
            name = "Address";
            sw = rw;
            hw = r;
        } val[31:0];
    } CS_A_0 @0x28;

    reg {
        name = "CS 0 Mask";
        field {
            name = "Mask";
            sw = rw;
            hw = r;
        } val[31:0];
    } CS_M_0 @0x2C;

    reg {
        name = "CS 1 Base Address";
        field {
            name = "Address";
            sw = rw;
            hw = r;
        } val[31:0];
    } CS_A_1 @0x30;

    reg {
        name = "CS 1 Mask";
        field {
            name = "Mask";
            sw = rw;
            hw = r;
        } val[31:0];
    } CS_M_1 @0x34;

    reg {
        name = "CS 2 Base Address";
        field {
            name = "Address";
            sw = rw;
            hw = r;
        } val[31:0];
    } CS_A_2 @0x38;

    reg {
        name = "CS 2 Mask";
        field {
            name = "Mask";
            sw = rw;
            hw = r;
        } val[31:0];
    } CS_M_2 @0x3C;

    reg {
        name = "CS 3 Base Address";
        field {
            name = "Address";
            sw = rw;
            hw = r;
        } val[31:0];
    } CS_A_3 @0x40;

    reg {
        name = "CS 3 Mask";
        field {
            name = "Mask";
            sw = rw;
            hw = r;
        } val[31:0];
    } CS_M_3 @0x44;

    reg {
        name = "XIP Command";
        desc = "SPI opcode and I/O widths used for automatic memory-mapped
                (XIP) reads triggered by an AXI read hitting the flash's
                mapped address range. Reset values (cmd=0x03, data_mode=0,
                addr_mode=0, all Standard) preserve the previous hardcoded,
                zero-dummy, single-lane behavior exactly, so existing
                designs and software are unaffected unless this register
                is explicitly reprogrammed.";
        field {
            name = "Command";
            desc = "SPI opcode byte, e.g. 0x03 (Standard Read), 0x0B
                    (Fast Read), 0x3B (Dual Output Fast Read), 0x6B
                    (Quad Output Fast Read).";
            sw = rw;
            hw = r;
            reset = 8'h03;
        } cmd[7:0];
        field {
            name = "Data I/O Mode";
            desc = "Data-phase I/O width: 0=Standard (single I/O), 1=Dual,
                    2=Quad. Matches spi_controller.sv's own
                    cfg_spicmd_i[31:30] convention -- e.g. data_mode=2 for
                    0x6B/0xEB.";
            sw = rw;
            hw = r;
            reset = 0;
        } data_mode[9:8];
        field {
            name = "Address I/O Mode";
            desc = "Address-phase I/O width, INDEPENDENT of Data I/O
                    Mode: 0=Standard (single I/O), 1=Dual, 2=Quad. Matches
                    spi_controller.sv's own cfg_spicmd_i[29:28] convention.
                    Most fast-read opcodes (0x0B/0x3B/0x6B) keep the
                    address single-lane even when the data phase is
                    dual/quad -- leave this at 0 (Standard) for those.
                    Only opcodes with their own quad/dual ADDRESS phase
                    (e.g. 0xEB, 0xBB -- not yet fully supported here, see
                    the missing mode-byte phase) need this set to
                    1 or 2.";
            sw = rw;
            hw = r;
            reset = 0;
        } addr_mode[11:10];
    } XIP_CMD @0x48;

    reg {
        name = "XIP Dummy Cycles";
        desc = "Dummy cycle count used for automatic memory-mapped (XIP)
                reads. Reset value 0 matches CMD 0x03's own zero-dummy
                semantics exactly. Must be reprogrammed together with
                XIP_CMD if switching to a fast-read opcode (e.g. 0x0B)
                that requires dummy cycles -- check the target flash's
                own datasheet for the required count (commonly 8 for
                0x0B/0x3B/0x6B at max frequency, sometimes fewer via the
                flash's own configuration register).";
        field {
            name = "Dummy";
            sw = rw;
            hw = r;
            reset = 0;
        } dum[7:0];
    } XIP_DUM @0x4C;

    reg {
        name = "XIP Address Length";
        desc = "Address phase length in bits for automatic memory-mapped
                (XIP) reads. Reset value 24 (3-byte addressing) preserves
                the previous hardcoded behavior exactly. Set to 32 for
                4-byte addressing, required by larger-density flash parts
                (typically >128Mbit) using opcodes such as 0x13/0x0C/0x6C
                or a flash-side extended-address-mode configuration.";
        field {
            name = "Length";
            sw = rw;
            hw = r;
            reset = 24;
        } bits[7:0];
    } XIP_ADDRLEN @0x50;

    reg {
        name = "XIP Mode Byte";
        desc = "Optional mode-byte (M7-M0) phase for automatic memory-mapped
                (XIP) reads, sent after ADDR and before DUMMY -- required by
                real Quad/Dual I/O opcodes (e.g. 0xEB, 0xBB) that interleave
                a mode byte between address and dummy cycles at the same
                I/O width as XIP_CMD's own addr_mode field. Reset value
                len=0 disables this phase entirely, preserving the previous
                hardcoded behavior exactly for the default 0x03 path and
                every other opcode that doesn't need it.";
        field {
            name = "Mode Value";
            sw = rw;
            hw = r;
            reset = 0;
        } val[7:0];
        field {
            name = "Mode Length";
            sw = rw;
            hw = r;
            reset = 0;
        } len[15:8];
    } XIP_MODE @0x58;
};
